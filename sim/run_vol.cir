* volume law with the 10k taper resistor, and X9C104 +/-20% channel mismatch
.include amp.cir
Rlaw wip 0 10k
.control
op
let vo = v(out1)
let vn = v(nf1)
echo RESULT op out1 $&vo nf1 $&vn
foreach x 1 0.9 0.8 0.7 0.6 0.5 0.4 0.3 0.2 0.15 0.1 0.05 0.02 0.01
  alterparam X = $x
  foreach rp 100k 80k 120k
    alterparam RPOT = $rp
    reset
    ac lin 1 1000 1000
    let g = vdb(spk)
    echo RESULT vol x $x rpot $rp gain_db $&g
    destroy all
  end
end
.endc
.end
