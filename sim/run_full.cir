* DC: output bias and mute current, three mute states; AC: both channels at 1 kHz
.include amp_full.cir
.control
op
let o1 = v(out1)
let o2 = v(out2)
let im = i(vcc)
let vm = v(mute)
echo RESULT play out1 $&o1 out2 $&o2 vmute $&vm
alterparam VCTL = 3.3
reset
op
let vm = v(mute)
let vmv = v(mv)
let ib = v(c1)
echo RESULT gpio_mute vmute $&vm mv $&vmv q1c $&ib
alterparam VCTL = 0
alterparam RSW = 0.05
reset
op
let vm = v(mute)
let vmv = v(mv)
echo RESULT switch_mute vmute $&vm mv $&vmv
alterparam RSW = 1e9
alterparam VCC = 12
alterparam VCTL = 3.3
reset
op
let vm = v(mute)
let vmv = v(mv)
echo RESULT gpio_mute_12v vmute $&vm mv $&vmv
alterparam VCC = 13.2
alterparam VCTL = 0
reset
ac lin 1 1000 1000
let g1 = vdb(spk1)
let g2 = vdb(spk2)
echo RESULT ac g1 $&g1 g2 $&g2
.endc
.end
